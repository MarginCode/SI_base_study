# Ansys Electronics Desktop project, version 2024.2
materials:
  vacuum: permittivity=1
  Core_38: permittivity=3.8 dielectric_loss_tangent=0.02
  copper: permeability=0.999991 conductivity=58000000
  air: permittivity=1.0006 permeability=1.0000004

design HFSSDesign1 (HFSS, HFSS Terminal Network, model units mm)
variables:
  ylen = 600mil
  xlen = 400mil
  T = 1.2mil
  Tsub = 3.24mil
  w_t = 6mil
  U_len = 280mil
  U_w = 100mil
  Air_ext = 20mil
geometry:
  plane [copper] = box(corner=(-xlen/2, -ylen/2, 0mm), size=(xlen, ylen, t))
  Core [Core_38] = box(corner=(-xlen/2, -ylen/2, t), size=(xlen, ylen, Tsub))
  Polyline1 = polyline(z=T+Tsub, xy: (-U_w/2, -U_len/2) (-U_w/2, U_len/2) (U_w/2, U_len/2) (U_w/2, -U_len/2))
  Trace [copper] = rectangle(corner=(-U_w/2, -U_len/2, T+Tsub), z_size=T, x_size=-w_t)
  Trace.sweep_along_path(Polyline1)
  AirBox [air] = box(corner=(-xlen/2, -ylen/2, -Air_ext), size=(xlen, ylen, Air_ext+T+Tsub+T+Air_ext))
  P1 = rectangle(corner=(-U_w/2, -U_len/2, T+Tsub), z_size=-Tsub, x_size=-w_t)
  P2 = rectangle(corner=(U_w/2, -U_len/2, T+Tsub), z_size=-Tsub, x_size=w_t)
boundaries and excitations:
  Rad1: Radiation Objects=AirBox
  Trace_T1: Terminal port=1 Edges=Trace.edge(at (-1.3462, -3.556, 0.112776)) TerminalResistance=50ohm
  Trace_T2: Terminal port=2 Edges=Trace.edge(at (1.3462, -3.556, 0.112776)) TerminalResistance=50ohm
  1: Lumped Port Faces=P1.face LumpedPortType=Terminal Impedance=50ohm
  2: Lumped Port Faces=P2.face LumpedPortType=Terminal Impedance=50ohm
  reference conductors: plane
mesh:
  Length1: LengthBased Objects=plane MaxLength=20mil
setups:
  Setup1: HfssDriven Frequency=1Hz MaxDeltaS=0.02 MaximumPasses=50 MinimumPasses=1 MinimumConvergedPasses=2 PercentRefinement=30 BasisOrder=-1 PortAccuracy=2 DrivenSolverType="Direct Solver"
source amplitudes:
  1:1: 1V 0deg
  2:1: 0V 0deg
field plots:
  Mag_Jsurf1: Jsurf over plane.face(all 6) on Setup1 : LastAdaptive at Freq=1e-09GHz Phase=0deg
  Vector_Jsurf1: Jsurf_V over plane.face(all 6) on Setup1 : LastAdaptive at Freq=1e-09GHz Phase=0deg
